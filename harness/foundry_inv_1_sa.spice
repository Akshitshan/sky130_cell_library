.subckt sky130_fd_sc_hd__inv_1 A VGND VNB VPB VPWR Y
X0 VGND A Y VNB sky130_fd_pr__nfet_01v8 w=0.65 l=0.15 sa=0.265 sb=0.265
X1 VPWR A Y VPB sky130_fd_pr__pfet_01v8_hvt w=1 l=0.15 sa=0.265 sb=0.265
.ends
