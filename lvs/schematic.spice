** sch_path: /home/akshit/sky130_cell_library/xschem_project/inverter/inverter.sch
.subckt inverter Vin Vout Vdd GND
*.PININFO Vin:I Vout:O Vdd:B GND:B
XM1 Vout Vin Vdd Vdd sky130_fd_pr__pfet_01v8 L=0.15 W=0.84 nf=1 ad=0.2436 as=0.2436 pd=2.26 ps=2.26 nrd=0.345238095238095
+ nrs=0.345238095238095 sa=0 sb=0 sd=0 mult=1
XM2 Vout Vin GND GND sky130_fd_pr__nfet_01v8 L=0.15 W=0.42 nf=1 ad=0.1218 as=0.1218 pd=1.42 ps=1.42 nrd=0.69047619047619
+ nrs=0.69047619047619 sa=0 sb=0 sd=0 mult=1
.ends
