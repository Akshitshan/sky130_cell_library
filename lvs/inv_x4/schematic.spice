** sch_path: /home/akshit/sky130_cell_library/xschem_project/inv_x4/inv_x4.sch
.subckt inv_x4 Vin Vout Vdd GND
*.PININFO Vin:I Vout:O Vdd:B GND:B
XM1 Vout Vin Vdd Vdd sky130_fd_pr__pfet_01v8 L=0.15 W=3.36 nf=1 ad=0.9744 as=0.9744 pd=7.3 ps=7.3 nrd=0.0863095238095238
+ nrs=0.0863095238095238 sa=0 sb=0 sd=0 mult=1
XM2 Vout Vin GND GND sky130_fd_pr__nfet_01v8 L=0.15 W=1.68 nf=1 ad=0.4872 as=0.4872 pd=3.94 ps=3.94 nrd=0.172619047619048
+ nrs=0.172619047619048 sa=0 sb=0 sd=0 mult=1
.ends
